* ===============================================================
* EHD PSU driver-chain netlist (LLC + PQ26/20 xfmr + CW + EHD load)
* Generated by ehdpsu.spice -- open locally in LTspice/QSPICE/ngspice.
* This file is an ARTIFACT: it is NOT executed in the build sandbox.
* Design: V_op=22 kV, f_sw=250 kHz, N_stages=5, C_stage=1 nF.
* Target: single EHD cell, ~80-120 W, 3-5 s bursts.
* ===============================================================

* ---------------------------------------------------------------
* LLC half-bridge primary
* f_sw = 250000 Hz, period = 4e-06 s, dead-time = 8e-08 s/edge.
* Ref: Steigerwald, IEEE TPEL 1988 (LLC resonant tank).
* ---------------------------------------------------------------
Vbus vbus 0 DC 400.0
* Complementary gate drives (PULSE) with dead-time.
Vg_hi ghi 0 PULSE(0 12 0 8e-08 8e-08 1.84e-06 4e-06)
Vg_lo glo 0 PULSE(0 12 2e-06 8e-08 8e-08 1.84e-06 4e-06)
* High-side and low-side switches, as ideal voltage-controlled switches.
* Syntax: Sxxx n+ n- nc+ nc- <model>  -- power path, then the CONTROL pair.
* The control pairs are ground-referenced, which is an idealisation: a real half-bridge
* references the high-side gate to the switching node and needs a bootstrap or an
* isolated supply. An ideal switch does not care about its own source potential, so this
* models the topology's behaviour and says nothing about gate-drive feasibility.
S1 vbus sw ghi 0 SW
S2 sw 0 glo 0 SW
.model SW SW(Ron=0.05 Roff=1e9 Vt=6 Vh=0.5)
* Resonant tank: series Lr (also lumps primary leakage) + Cr.
Lr sw nr 6e-05
Cr nr pri_p 6.8e-09
* Magnetizing inductance across the primary winding.
Lm pri_p 0 0.0003

* ---------------------------------------------------------------
* PQ26/20 HF transformer as coupled inductors.
* Turns ratio (sec:pri) = 12.0; K coupling = 0.98.
* Leakage inductance is represented by the series Lr in the tank.
* NOTE: interwinding (primary-secondary) capacitance is a real HV
* concern (couples switching noise + shifts resonance); model it by
* adding a small C between pri_p and sec_p if you need common-mode
* fidelity. Here we lump only the secondary self-capacitance C_sec.
* ---------------------------------------------------------------
L_pri pri_p 0 0.0003
L_sec sec_p sec_n 0.043199999999999995
K_xfmr L_pri L_sec 0.98
* Secondary self-capacitance lump across the secondary winding.
C_sec sec_p sec_n 4.7e-11
* Secondary low side is the CW ladder ground reference.
Rsec_gnd sec_n 0 1e-3

* ---------------------------------------------------------------
* Ultrafast HV rectifier model (e.g. 20 kV fast-recovery stack).
* High BV (Vrrm), small Cjo (low charge storage), small tt.
* REVERSE-RECOVERY NOTE: real HV stacks show finite trr; tt below is a
* first-order proxy. For hard-switched CW ripple studies, refine tt/Cjo
* from the chosen part's datasheet (trr, Qrr) before trusting losses.
* ---------------------------------------------------------------
.model DHV D(IS=5e-09 N=2.0 RS=25.0 BV=20000.0 CJO=2e-12 TT=5e-09)

* ---------------------------------------------------------------
* 5-stage Cockcroft-Walton multiplier (half-wave cascade).
* Per-stage caps 1e-09 F, from the profile; ultrafast HV rectifier .model below.
* ---------------------------------------------------------------
Cc1 sec_p cw_a1 1e-09
Dd1a sec_n cw_a1 DHV
Dd1b cw_a1 cw_b1 DHV
Cs1 cw_b1 sec_n 1e-09
Cc2 sec_p cw_a2 1e-09
Dd2a cw_b1 cw_a2 DHV
Dd2b cw_a2 cw_b2 DHV
Cs2 cw_b2 cw_b1 1e-09
Cc3 sec_p cw_a3 1e-09
Dd3a cw_b2 cw_a3 DHV
Dd3b cw_a3 cw_b3 DHV
Cs3 cw_b3 cw_b2 1e-09
Cc4 sec_p cw_a4 1e-09
Dd4a cw_b3 cw_a4 DHV
Dd4b cw_a4 cw_b4 DHV
Cs4 cw_b4 cw_b3 1e-09
Cc5 sec_p cw_a5 1e-09
Dd5a cw_b4 cw_a5 DHV
Dd5b cw_a5 cw_b5 DHV
Cs5 cw_b5 cw_b4 1e-09
* CW DC output node: cw_b5
Rout cw_b5 cw_out 1

* ---------------------------------------------------------------
* EHD behavioral load (reusable subcircuit)
* Quadratic Townsend corona law: I = k*V*(V - V_onset), V>V_onset.
* EHD load is a STATIC approximation of the quadratic Townsend corona law I = k*V*(V - V_onset); it models the steady-state I-V curve only, with NO plasma dynamics (no ion transit lag, no streamer/spark transition, no frequency dependence). k and V_onset come from ehdpsu.physics.
* k       = 2.7668749999999996e-12 A/V^2  (parallel-plate, labeled model parameter)
* V_onset = 2740.6671272441477 V
* Pins: hv = emitter/high-voltage node, gnd = collector/return.
* ---------------------------------------------------------------
.subckt EHD_LOAD hv gnd
.param k=2.7668749999999996e-12 Vonset=2740.6671272441477
* B-source: current flows hv->gnd (loads the CW output) only above onset.
Behd hv gnd I = (V(hv,gnd) > Vonset) ? (k*V(hv,gnd)*(V(hv,gnd) - Vonset)) : 0
.ends EHD_LOAD

* ---------------------------------------------------------------
* Instantiate the EHD load across the CW multiplier output.
* ---------------------------------------------------------------
Xload cw_out 0 EHD_LOAD

* ---------------------------------------------------------------
* Transient analysis. ACTIVE, not a commented suggestion.
*
* Until 2026-09-18 this directive was emitted commented out, under the heading
* 'Suggested analysis (uncomment locally)'. That made the tracked artifact unrunnable as
* generated: an operator had to hand-edit it before it would do anything, and the edited
* file is no longer the file whose SHA-256 the run record carries. A provenance chain that
* requires an unrecorded hand-edit in the middle is not a provenance chain.
*
* uic skips the DC operating point, which is what a Cockcroft-Walton ladder starting from
* fully discharged capacitors needs.
*
* WHETHER 2 ms REACHES STEADY STATE IS UNVERIFIED AND MUST BE CHECKED BY INSPECTION.
* 2 ms is 500 switching cycles at 250 kHz. An order-of-magnitude estimate says the smoothing
* column needs roughly 4.4 uC to reach 22 kV (5 x 1 nF in series = 200 pF), which at a few
* mA of charging current lands around 1-2 ms -- so 2 ms is plausible and the previous 200 us
* was almost certainly far too short. That estimate is an estimate. If the output is still
* rising at the end of the run, the run is NOT a result: extend it and re-run. A droop or
* ripple figure read off a still-charging waveform is a number about the transient, quoted
* as a number about the steady state.
* ---------------------------------------------------------------
.tran 0 2m 0 20n uic
.end
